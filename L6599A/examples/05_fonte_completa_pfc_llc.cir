* Fonte completa: PFC UC3854 (U-134) + LLC L6599A (AN3233), 115 VCA -> 12 V / 150 W
*
* Os dois modelos juntos, como na placa EVL150W-ADP-SR da AN3233 (que usa o
* L6563H no PFC; aqui o PFC e o UC3854, cujo modelo ja temos, com o circuito
* da Figura 6 da U-134).
*
* PFC (UC3854, modelo do repositorio UC3854-spice-model, copiado em
* examples/UC3854.lib): exatamente os componentes do exemplo 02 daquele
* repositorio (U-134 Figura 6: L = 1 mH, Rs = 0.25, compensacoes, RSET 10k,
* CT 1.2 nF, 104 kHz), com UMA mudanca: o capacitor do barramento e o C9 da
* AN3233, 100 uF / 450 V, em vez dos 450 uF da U-134 (o conversor e de 150 W,
* nao de 250 W).  Rede de 115 VCA / 60 Hz.
*
* LLC (L6599A): o circuito do exemplo 02 sem mudar nada, alimentado pelo
* barramento do PFC.  A partida dele leva ~60 ms (soft-start de 4.7 uF e a
* compensacao 47k / 100 nF da malha de tensao).  O pino LINE (divisor 6.6 Meg / 27k) so deixa o LLC
* partir com o barramento acima de ~386 V e o desliga abaixo de 300 V.
*
* PFC_STOP: na AN3233 ele vai ao PFC_OK do L6563H, que so PAUSA o PFC.  O
* UC3854 nao tem entrada equivalente: o ENA dele descarrega o soft-start
* (1 uF a 14 uA -> ~0.5 s para voltar).  Ligado ao ENA, o breve STBY baixo da
* partida do L6599A (o opto U4 depende da saida, ainda em 0 V) desliga o PFC
* de vez: o barramento cai de 400 V ate os 300 V do brownout do LINE e o LLC
* para.  Por isso aqui o PFC_STOP so e observado.
*
* Alimentacoes auxiliares: 18 V para o UC3854 (UVLO de 16 V) e 15 V para o
* L6599A, fontes ideais (na placa: bomba de carga + enrolamento auxiliar).
*
* Partida: o PFC comeca perto do regime (barramento em 400 V, compensacoes
* carregadas, IC= e uic, como no exemplo do UC3854); o LLC parte do zero com
* o soft-start dele.  Carregar 100 uF a 400 V a partir da rede e o soft-start
* do UC3854 levaria centenas de ms.
*
* A simulacao vai ate 76 ms: um pouco depois disso o ngspice para com
* "timestep too small" no no da rede (lado do PFC).  Os dois ultimos ciclos
* de 60 Hz (43 a 76 ms) ja pegam a fonte em regime.
*
* Rode e olhe: i(Vline) contra v(line,lr), v(bus), v(out), i(Lr), v(hb)

.include ../L6599A.lib
.include UC3854.lib

.param VAC=115 RLOAD=0.96 NEFF=15.9

* ============================ PFC UC3854 =====================================
Vline line lr SIN(0 {VAC*1.4142} 60)
Rline line nl 0.2
Rflt  lr 0 10Meg
D1 nl  rp DBR
D2 lr  rp DBR
D3 rn  nl DBR
D4 rn  lr DBR
Cin nl lr 0.47u

L1   rp  sw 1m
S1   sw  0 gate 0 SWP
Csw  sw  0 220p
D0   sw  bus DBOOST
Cbus bus 0 100u IC=400
Rs   0 rn 0.25

Vcc18 vcc18 0 18
Rena  vcc18 ena 22k
C3    vref 0 1u

Rvi bus vsense 511k
Rvd vsense 0 10k
Rvf vaout vsense 174k
Cvf vaout vsense 47n IC=-3.9
Css ss 0 1u IC=8

Rvac rp iac 620k
Rb1  vref iac 150k
Rff1 rp vffc 910k
Cff1 vffc 0 0.1u IC=10.7
Rff2 vffc vrms 91k
Rff3 vrms 0 20k
Cff2 vrms 0 0.47u IC=1.9

Rmo mult rn 3.9k
Rci isense 0 3.9k
Rcz isense ncz 20k
Ccz ncz caout 620p
Ccp isense caout 62p

Rpk1 vref pklmt 10k
Rpk2 pklmt rn 1.8k
Cpk  pklmt 0 100p

Rset rset 0 10k
Ct   ct 0 1.2n

Rg  gtdrv gate 10
Cgs gate 0 2n
Ds  0 gtdrv DSCH

*   GND PKLMT CAOUT ISENSE MULTOUT IAC VAOUT VRMS VREF ENA VSENSE RSET SS CT VCC GTDRV
XPFC 0  pklmt caout isense mult  iac vaout vrms vref ena vsense rset ss ct vcc18 gtdrv UC3854

* PFC_STOP do L6599A: so observado (pull-up de 100k para os 15 V).  Ver o
* cabecalho: no UC3854 nao ha onde ligar.
Rpfc vcc15 pfcstop 100k

* ============================ LLC L6599A =====================================
Vcc15 vcc15 0 PWL(0 0 10u 0 60u 15)

* --- meia-ponte ---------------------------------------------------------------
* MOSFETs como condutancia suave de 0 a 1/0.7 ohm entre Vgs = 3 V e 5 V
* (uma chave ideal "S" com diodo de corpo faz o passo de tempo despencar
* nas comutacoes ZVS)
Bh   bus hb I = V(bus,hb)*(max(0,min(1,(V(hvgm,hb)-3)/2))/0.7 + 1e-7)
Dh   hb bus DBODY
Coh  bus hb 100p
Bl   hb 0 I = V(hb)*(max(0,min(1,(V(lvgm)-3)/2))/0.7 + 1e-7)
Dl   0 hb DBODY
Col  hb 0 100p
Rgh  hvg hvgm 47
Cgh  hvgm hb 1.5n
Rgl  lvg lvgm 47
Cgl  lvgm 0 1.5n

* --- tanque e transformador ideal com Lm --------------------------------------
* Modelo "tudo no primario" (APR) a partir do que a AN3233 da: Lp = 800 uH
* (secundario aberto) e Ls = 100 uH (secundario em curto).  Com acoplamento
* k = sqrt(1 - Ls/Lp) = 0.935 o modelo e Lr = Ls, Lm = Lp - Ls e uma relacao
* IDEAL de k*Np/Ns = 0.935*17 = 15.9 (nao 17).  Com 17 o conversor nao chega
* a 12 V a plena carga; com 15.9 ele opera logo acima da ressonancia, em
* ~120 kHz, como a AN3233 descreve.
Lr   hb pa 100u
Lm   pa pb 700u
Cr   pb 0 22n IC=200
Es1  s1a 0 pa pb {1/NEFF}
Vm1  s1a s1 0
Fp1  pa pb Vm1 {1/NEFF}
Es2  0 s2a pa pb {1/NEFF}
Vm2  s2a s2 0
Fp2  pa pb Vm2 {-1/NEFF}
Rsec1 s1 0 10Meg
Rsec2 s2 0 10Meg

* --- retificacao sincrona (como diodos de baixa queda) e saida --------------
* na placa a tomada central e o +12 V e os SR ficam no retorno; aqui a
* tomada central e o terra e os "SR" vao para a saida (eletricamente igual)
Dr1  s1 out DSR
Dr2  s2 out DSR
Co   out 0 2350u
Resr out oc 2m
Rsns oc  ol 2m
Vio  ol  ol2 0
Rload ol2 0 {RLOAD}

* --- sensor de corrente capacitivo (ISEN) ------------------------------------
C27  pb n27 220p
R41  n27 n10 100
D10  n10 isen D4148
D11  0 n10 D4148
R39  isen 0 160
C25  isen 0 2.2u

* --- L6599AD -------------------------------------------------------------------
Cf   cf 0 330p
R31  rfmin 0 12k
R44  rfmin css 6.2k
C18  css 0 4.7u
C45  delay 0 220n
R24  delay 0 1Meg
Rh1  bus l1 2.2Meg
Rh2  l1 l2 2.2Meg
Rh3  l2 lsense 2.2Meg
R10  lsense 0 27k
C43  lsense 0 4.7n IC=1.6
R60  dis 0 10k
C19  vboot hb 100n
C40  vcc15 0 100n
*   CSS DELAY CF RFMIN STBY ISEN LINE DIS PFC_STOP GND LVG VCC NC OUT HVG VBOOT
X1   css delay cf rfmin stby isen lsense dis pfcstop 0 lvg vcc15 nc hb hvg vboot L6599A

* --- realimentacao: lado primario --------------------------------------------
R34  rfmin nd17 27k
D17  nd17 fbc D4148
C41  fbc 0 22n
R32  fbc stby 47
R36  stby 0 1.8Meg
C44  stby 0 470p
* U3: fototransistor com saturacao; CTR = 0.3, o do SFH617A-2 com ~0.1 mA
* no LED (curva CTR x IF do fabricante)
Bu3  fbc 0 I = 0.3*max(0,I(Vled3))*min(1,uramp(V(fbc))/0.2)
* U4: liga RFMIN ao STBY enquanto a carga e alta - saturado, uma chave de
* ~200 ohm quando o LED dele conduz mais que ~50 uA
Bu4  rfmin stby I = V(rfmin,stby)/200*max(0,min(1,(I(Vled4)-30u)/40u))

* --- realimentacao: lado secundario (TSM1014, TSC101) ------------------------
R43  out n36 51
C36  n36 0 1u
R42  n36 la3 1k
D3l  la3 lk3 DLED
Vled3 lk3 cvout 0
R49  out cvm 91k
R50  cvm 0 12k
R51  cvm 0 82k
R48  cvout n48 47k
C34  n48 cvm 100n
* amplificador CV: 100 dB, 1 MHz, saida de 0.1 V ate Vout (o Vcc do TSM1014)
Bcv  0 ncv I = 1m*(1.25-V(cvm))
Rcv  ncv 0 100Meg
Ccv  ncv 0 159p
* grampo do no interno (sem ele o integrador "enrola" a 1e5 V na partida,
* com a saida em 0 V, e leva dezenas de ms para voltar)
Bcvl ncv 0 I = uramp(V(ncv)-max(0.2,V(out))) - uramp(-V(ncv))
Bcvo ncvo 0 V = max(0.1, min(uramp(V(out)), V(ncv)))
Rcvo ncvo cvout 20
* TSC101: 100 x queda no R57 (2 mohm), filtro R71 = 1k / C32 = 1 uF
Btsc ntsc 0 V = 100*(V(oc)-V(ol))
R71  ntsc ccm 1k
C32  ccm 0 1u
* comparador CC: referencia 1.25 V * 22k/(330k+22k) = 78 mV (~0.39 A)
R72  vr125 ccp 330k
Vr125 vr125 0 1.25
R70  ccp 0 22k
C47  ccp 0 1n
R64  ccout ccp 10Meg
Bcc  ncco 0 V = 0.1 + uramp(V(out)-1.1)*max(0,min(1,(V(ccp)-V(ccm))*1000+0.5))
Rcco ncco ccout 100
R68  out la4 39k
D4l  la4 lk4 DLED
Vled4 lk4 ccout 0

.model DBODY  D(IS=1e-11 N=1.2 RS=0.05 CJO=10p)
* SR como diodo: N = 1 (um N menor, para imitar a queda baixa de um MOSFET,
* deixa a exponencial tao ingreme que o passo de tempo despenca)
.model DSR    D(IS=1e-3 N=1 RS=3m CJO=1n)
.model D4148  D(IS=2.5n N=1.8 RS=0.5 CJO=4p TT=5n)
.model DLED   D(IS=1e-18 N=1.5 RS=5)
.model SWP    SW(Ron=0.25 Roff=1Meg Vt=5 Vh=1)
.model DBOOST D(IS=1e-9 N=1.6 RS=0.05 CJO=50p TT=25n BV=600)
.model DBR    D(IS=1e-9 N=1.8 RS=0.02 CJO=100p)
.model DSCH   D(IS=1e-5 N=1.1 RS=0.05)

* gear: amortece o "ringing" numerico das comutacoes da meia-ponte
.options method=gear
.tran 40n 76m 0 40n uic
.end
