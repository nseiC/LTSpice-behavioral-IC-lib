* IR2110 test 04 - switching times (Figure 3 test circuit, CL = 1 nF)
*  VCC = VBS = VDD = 15 V:  ton 120 / toff 94 / tsd 110 / tr 25 / tf 17 ns
*  typ, MT <= 10 ns (IR2110).  Figures 7B/8B (VBIAS 10 and 20 V), 7C/8C
*  (VDD = 5 V), and KD = 1.3 / KE = 1.8 against the max column.
.include ir2110_ng.lib
.param VB=15 VD=15 KDP=1 KEP=1
Vcc vcc 0 {VB}
Vdd vdd 0 {VD}
Vbs vb vs {VB}
Vs  vs 0 0
Vin in 0 PULSE(0 {VD} 1u 10n 10n 2u 5u)
Vsd sd 0 0
X1 lo 0 vcc vs vb ho vdd in sd in 0 IR2110 KD={KDP} KE={KEP}
Ch ho vs 1n
Cl lo 0 1n
* SD-timing instance (inputs high, SD pulse)
Vs2 sd2 0 PULSE(0 {VD} 2u 10n 10n 1u 5u)
Vh2 h2 0 PWL(0 0 0.5u 0 0.51u {VD})
X2 lo2 0 vcc vs vb2 ho2 vdd h2 sd2 h2 0 IR2110
Vb2 vb2 vs {VB}
Ch2 ho2 vs 1n
Cl2 lo2 0 1n
.control
set noaskquit
echo "--- test 04: switching times ---"
define chk(x, t, tol) abs(x/t-1) < tol
* --- typical, 15 V ---
tran 0.1n 4u 0 0.5n
let vh = v(ho)-v(vs)
meas tran ton TRIG v(in) VAL=7.5 RISE=1 TARG vh VAL=1.5 RISE=1
meas tran tr  TRIG vh VAL=1.5 RISE=1 TARG vh VAL=13.5 RISE=1
meas tran toff TRIG v(in) VAL=7.5 FALL=1 TARG vh VAL=13.5 FALL=1
meas tran tf  TRIG vh VAL=13.5 FALL=1 TARG vh VAL=1.5 FALL=1
meas tran tonl TRIG v(in) VAL=7.5 RISE=1 TARG v(lo) VAL=1.5 RISE=1
meas tran toffl TRIG v(in) VAL=7.5 FALL=1 TARG v(lo) VAL=13.5 FALL=1
meas tran tsd TRIG v(sd2) VAL=7.5 RISE=1 TARG v(ho2) VAL=13.5 FALL=1
meas tran tsdl TRIG v(sd2) VAL=7.5 RISE=1 TARG v(lo2) VAL=13.5 FALL=1
if chk(ton,120n,0.02) & chk(toff,94n,0.02) & chk(tr,25n,0.02) & chk(tf,17n,0.02)
  echo "PASS 04a 15 V: ton $&ton  toff $&toff  tr $&tr  tf $&tf  (120/94/25/17 ns typ)"
else
  echo "FAIL 04a 15 V: ton $&ton toff $&toff tr $&tr tf $&tf"
end
if chk(tsd,110n,0.03) & chk(tsdl,110n,0.03)
  echo "PASS 04b tsd: HO $&tsd s, LO $&tsdl s (110 ns typ)"
else
  echo "FAIL 04b tsd $&tsd $&tsdl"
end
let mt = max(abs(ton-tonl), abs(toff-toffl))
if mt < 10n
  echo "PASS 04c delay matching HO/LO: $&mt s (MT <= 10 ns)"
else
  echo "FAIL 04c MT $&mt"
end
* --- VBIAS 10 V and 20 V (Figures 7B, 8B, 10B, 11B) ---
alterparam VB = 10
reset
tran 0.1n 4u 0 0.5n
let vh = v(ho)-v(vs)
meas tran ton TRIG v(in) VAL=7.5 RISE=1 TARG vh VAL=1 RISE=1
meas tran toff TRIG v(in) VAL=7.5 FALL=1 TARG vh VAL=9 FALL=1
meas tran tr  TRIG vh VAL=1 RISE=1 TARG vh VAL=9 RISE=1
meas tran tf  TRIG vh VAL=9 FALL=1 TARG vh VAL=1 FALL=1
if chk(ton,140n,0.04) & chk(toff,110n,0.04) & chk(tr,28n,0.05) & chk(tf,9n,0.1)
  echo "PASS 04d VBIAS = 10 V: ton $&ton toff $&toff tr $&tr tf $&tf (Fig. 7B/8B/10B/11B: 140/110/28/9 ns)"
else
  echo "FAIL 04d 10 V: $&ton $&toff $&tr $&tf"
end
alterparam VB = 20
reset
tran 0.1n 4u 0 0.5n
let vh = v(ho)-v(vs)
meas tran ton TRIG v(in) VAL=7.5 RISE=1 TARG vh VAL=2 RISE=1
meas tran toff TRIG v(in) VAL=7.5 FALL=1 TARG vh VAL=18 FALL=1
meas tran tr  TRIG vh VAL=2 RISE=1 TARG vh VAL=18 RISE=1
meas tran tf  TRIG vh VAL=18 FALL=1 TARG vh VAL=2 FALL=1
if chk(ton,100n,0.04) & chk(toff,76n,0.04) & chk(tr,22n,0.05) & chk(tf,26n,0.05)
  echo "PASS 04e VBIAS = 20 V: ton $&ton toff $&toff tr $&tr tf $&tf (Fig. 7B/8B/10B/11B: 100/76/22/26 ns)"
else
  echo "FAIL 04e 20 V: $&ton $&toff $&tr $&tf"
end
* --- VDD = 5 V (Figures 7C, 8C) ---
alterparam VB = 15
alterparam VD = 5
reset
tran 0.1n 4u 0 0.5n
let vh = v(ho)-v(vs)
meas tran ton TRIG v(in) VAL=2.5 RISE=1 TARG vh VAL=1.5 RISE=1
meas tran toff TRIG v(in) VAL=2.5 FALL=1 TARG vh VAL=13.5 FALL=1
if chk(ton,140n,0.06) & chk(toff,150n,0.06)
  echo "PASS 04f VDD = 5 V: ton $&ton toff $&toff (Fig. 7C/8C: ~140 / ~150 ns)"
else
  echo "FAIL 04f VDD 5 V: $&ton $&toff"
end
* --- max column: KD = 1.3, KE = 1.45 ---
alterparam VD = 15
alterparam KDP = 1.3
alterparam KEP = 1.8
reset
tran 0.1n 4u 0 0.5n
let vh = v(ho)-v(vs)
meas tran ton TRIG v(in) VAL=7.5 RISE=1 TARG vh VAL=1.5 RISE=1
meas tran tr  TRIG vh VAL=1.5 RISE=1 TARG vh VAL=13.5 RISE=1
meas tran toff TRIG v(in) VAL=7.5 FALL=1 TARG vh VAL=13.5 FALL=1
meas tran tf  TRIG vh VAL=13.5 FALL=1 TARG vh VAL=1.5 FALL=1
if chk(ton,150n,0.07) & chk(toff,125n,0.07) & chk(tr,35n,0.07) & chk(tf,25n,0.1)
  echo "PASS 04g KD=1.3 KE=1.8: ton $&ton toff $&toff tr $&tr tf $&tf (max column 150/125/35/25 ns)"
else
  echo "FAIL 04g max corner $&ton $&toff $&tr $&tf"
end
quit
.endc
.end
