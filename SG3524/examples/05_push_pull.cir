* SG3524 - PUSH-PULL com transformador, 24 V -> 5 V / 2 A
*
* Esta e a aplicacao-assinatura do SG3524: saidas SEPARADAS, cada uma
* comandando metade do primario com tomada central, alternadas em 180 graus e
* com o pulso de blanking garantindo que nunca conduzam juntas.  Cada saida
* roda na metade da frequencia do oscilador.
*
* RT=10k, CT=1.25n -> oscilador 80 kHz -> 40 kHz por saida.
*
* As saidas do CI NAO carregam a corrente do primario: o datasheet limita cada
* uma a 100 mA, e um push-pull de 5 V / 2 A pede ~2 A de pico no primario.
* Cada saida trabalha como seguidor de emissor (coletor no VIN, ~23 mA no
* resistor de 1k) e comanda uma chave externa low-side.  (Uma versao anterior
* deste exemplo ligava o primario direto nos coletores: 2 A de pico em cada
* transistor, Vce ~ 5,8 V, o estagio de potencia virava os 5 ohm do modelo e a
* resposta da malha mudava ~1,4 dB com a amplitude da injecao no FRA.)
*
* Compensacao (verificada com FRA, ver o README): Rcz + Ccz + Cp no pino 9,
* Cff no divisor, e a rede R-C amortecedora na saida, como no buck.
*
* Rode e olhe: v(vout), v(pa), v(pb), v(ct), i(Lpa), i(Lpb)
.include ../SG3524.lib
Vin vin 0 24
Rt rt 0 10k
Ct ct 0 1.25n
* realimentacao 5V -> 2.5V
Rfb1 vout inv 10k
* Cff: avanco de fase no divisor (zero em 1,6 kHz, polo em 3,2 kHz)
Cff  vout inv 10n
Rfb2 inv 0 10k
Rd1 vref ni 5k
Rd2 ni 0 5k
Css ni 0 470n IC=0
Rcz comp ncz 470
Ccz ncz 0 470n
Cp comp 0 4.7n
* saidas SEPARADAS como seguidores de emissor: coletores no VIN, cada emissor
* comanda uma chave low-side (Vea/Veb so medem a corrente de cada saida)
X1 inv ni osc clp clm rt ct 0 comp sd ea vin vin eb vin vref SG3524
Vea ea ga 0
Rga ga 0 1k
Veb eb gb 0
Rgb gb 0 1k
Sa  pa 0 ga 0 PSW
Sb  pb 0 gb 0 PSW
* transformador com tomada central no primario (metade B invertida), n = 0,5.
* 1 mH por metade do primario: a corrente magnetizante fica em ~0,14 A de
* pico.  Com 100 uH (versao anterior) eram 1,4 A - mais que a propria corrente
* de carga refletida - e essa energia tocava nos snubbers a cada abertura de
* chave: o ganho do estagio de potencia caia 20 dB a 1 kHz e dependia do
* passo do solver (11 graus entre 100 e 50 ns), e o FRA nao fechava.
Lpa vin pa 1m
Lpb pb vin 1m
Ls  ns1 ns2 250u
K1 Lpa Lpb 0.999
K2 Lpa Ls 0.999
K3 Lpb Ls 0.999
Rmag vin 0 1e7
* snubbers nos drenos
Rsa pa nsa 47
Csa nsa 0 2.2n
Rsb pb nsb 47
Csb nsb 0 2.2n
* ponte retificadora + filtro LC
Da ns1 nr DFW
Db ns2 nr DFW
Dc 0 ns1 DFW
Dd 0 ns2 DFW
Lf nr vout 22u
Cf vout ncf 470u IC=0
Rcf ncf 0 30m
* amortecedor R-C: sem ele o LC de saida tem Q ~ 5 e a fase despenca logo
* acima de 1,6 kHz
Rdmp vout nd 0.33
Cdmp nd 0 1000u IC=0
Rload vout 0 2.5
.model PSW SW(Ron=0.1 Roff=1Meg Vt=5 Vh=1)
.model DFW D(IS=5e-8 N=1.05 CJO=100p TT=20n)
* gear: amortece o "ringing" numerico das comutacoes da chave ideal.  Com o
* trapezoidal, na abertura da chave o no de comutacao oscila numericamente e
* injeta corrente falsa no indutor (saltos de amperes em um passo); a malha
* fica caotica e o FRA mede lixo.  Ver tools/fra e o README principal.
.options method=gear
* passo maximo 100 ns: o tempo morto aqui e ~67 ns (CT = 1,25 nF), e o pulso
* de blanking e o clock do flip-flop que alterna as saidas.  Com 500 ns o
* solver as vezes passa por cima dele e a mesma saida dispara duas vezes
* seguidas (21 de 94 pulsos) - num push-pull isso empurra o transformador
* para a saturacao.  Com 200 e 100 ns nenhuma falha em ~900 ciclos.  (Ver
* "What to put on the schematic" no README.)
.tran 100n 12m 0 100n uic
.end
