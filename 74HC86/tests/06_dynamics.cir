* 74HC86 test 06 - dynamic behaviour the tables imply but do not list
*  a) A and B switching together: the output must not glitch
*  b) a runt pulse much shorter than tpd is swallowed (inertial delay)
*  c) lifted ground: GND pin at +1 V, VCC pin at +5.5 V -> works on 4.5 V
*  d) VCC ramped 0 -> 5 V with the inputs fixed: output follows, no latch-up
*  e) load dependence: tpd grows with CL (150 pF slower than 50 pF)
.include 74hc86_ng.lib
Vcc vcc 0 PWL(0 0 1u 4.5)
Vs  s 0 PULSE(0 4.5 2u 6n 6n 500n 1u)
Vr  r 0 PULSE(0 4.5 2.2u 2n 2n 3n 1u)
* gate 1: A = B = s (simultaneous switching)   gate 2: runt pulse on A2
* gate 3: A3 = s, B3 = 0, CL = 50 pF            gate 4: same, CL = 150 pF
X1 s s y1 r 0 y2 0 y3 s 0 y4 s 0 vcc 74HC86
C3 y3 0 50p
C4 y4 0 150p
* lifted-ground instance
Vgl gl 0 1
Vvl vl 0 5.5
Vsl sl 0 PULSE(1 5.5 2u 6n 6n 500n 1u)
X2 sl gl yl gl gl q2 gl q3 gl gl q4 gl gl vl 74HC86
Cl yl gl 50p
.control
set noaskquit
echo "--- test 06: dynamics ---"
tran 0.1n 4u 0 0.5n
meas tran y1max MAX v(y1) from=1.5u to=4u
if (y1max < 0.45)
  echo "PASS 06a A and B switching together: no output glitch (max $&y1max V)"
else
  echo "FAIL 06a glitch $&y1max V"
end
meas tran y2max MAX v(y2) from=1.5u to=4u
if (y2max < 0.45)
  echo "PASS 06b 5 ns runt pulse swallowed (max $&y2max V)"
else
  echo "FAIL 06b runt $&y2max V"
end
meas tran tl TRIG v(sl) VAL=3.25 RISE=1 TARG v(yl) VAL=3.25 RISE=1
meas tran ylmin MIN v(yl) from=3.1u to=3.4u
if (tl < 21n) & (tl > 15n) & (ylmin > 5.4)
  echo "PASS 06c lifted ground (GND = 1 V): tpd $&tl s, output high = VCC pin"
else
  echo "FAIL 06c lifted ground tpd $&tl"
end
meas tran y3a FIND v(y3) AT=0.9u
if (y3a < 0.1)
  echo "PASS 06d VCC ramp 0 -> 4.5 V: output held at its logic level"
else
  echo "FAIL 06d $&y3a"
end
meas tran t3 TRIG v(s) VAL=2.25 RISE=1 TARG v(y3) VAL=2.25 RISE=1
meas tran t4 TRIG v(s) VAL=2.25 RISE=1 TARG v(y4) VAL=2.25 RISE=1
if (t4 > t3*1.3)
  echo "PASS 06e tpd grows with load: $&t3 s at 50 pF, $&t4 s at 150 pF"
else
  echo "FAIL 06e $&t3 $&t4"
end
quit
.endc
.end
