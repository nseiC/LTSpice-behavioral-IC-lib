* IR2111 - buck sincrono 48 V -> 12 V / 3 A, 50 kHz, malha fechada
*
*   48 V --[M1]--+--[L 100u]--+-- 12 V / 4 ohm (3 A)
*                |            |
*               [M2]       [Co 220u]
*                |            |
*               GND          GND
*
* UMA entrada: o PWM vai direto ao pino IN e o IR2111 gera HO (em fase) e LO
* (invertido) com o seu tempo morto interno de ~700 ns.  Bootstrap Dbs/Cbs
* a partir de VCC = 15 V.  A entrada e CMOS referida a VCC: o PWM precisa ir
* de 0 a 15 V (VIH = 9,5 V em VCC = 15 V).
*
* O tempo morto come ~0,7 us de cada pulso de HO (ton - toff), e nos dois
* tempos mortos o diodo de corpo de M2 conduz.  A malha corrige: o duty do
* PWM fica alguns % acima de Vout/Vin.
*
* Controle (comportamental, so para fechar a malha): amplificador de erro
* tipo III, rampa dente-de-serra de 3 V a 50 kHz, comparador PWM.
*   duty ~ 25 %, ganho do modulador Vin/Vrampa = 48/3 = 16
*   LC: f0 = 1,07 kHz;  ESR: 29 kHz;  cruzamento ~4 kHz
*   compensacao: zeros em 0,72 e 1,0 kHz, polos em 20 e 27 kHz
*   (ganho de malha medio: cruzamento 4,2 kHz, margem de fase 59 graus)
*
* Partida suave de 3 ms na referencia; degrau de carga 3 A -> 1,5 A em 8 ms.
*
* Vinj: fonte de 0 V em serie entre a saida e o divisor de realimentacao.
* No LTspice, troque Vinj pelo componente FRA para medir o ganho de malha.
*
* Rode e olhe: v(vout), v(sw), v(ho,sw), v(lo), v(in), v(vb,sw), i(L1)

.include ../IR2111.lib

.param VIN=48
Vin  vin 0 {VIN}
Vcc  vcc 0 15

* --- IR2111 + bootstrap ----------------------------------------------------
*  VCC IN COM LO VS HO VB
X1 vcc in 0 lo sw ho vb IR2111
Dbs  vcc vb DBOOT
Cbs  vb  sw 1u
Cvcc vcc 0 10u

* --- meia-ponte ------------------------------------------------------------
Rg1 ho g1 10
Rg2 lo g2 10
X_M1 vin g1 sw NMOS100
X_M2 sw  g2 0  NMOS100

* --- filtro e carga --------------------------------------------------------
L1   sw  nl 100u
Rdcr nl  vout 30m
Co   vout nc 220u
Resr nc  0 25m
* 8 ohm fixo + 8 ohm chaveado (desliga em 8 ms): 3 A -> 1,5 A
Rload vout 0 8
Rstep vout nst 8
Sstep nst 0 nstc 0 SLOAD
Vstep nstc 0 PWL(0 1 8m 1 8.001m 0)

* --- realimentacao: 12 V -> 2,5 V, injecao do FRA ---------------------------
Vinj nfb vout 0
R1   nfb inv 10k
Rb   inv 0 2.632k
R3   nfb n3 523
C3   n3  inv 15n
R2   inv n2 2.2k
C2   n2  comp 100n
C1   inv comp 2.7n

* --- amplificador de erro: 100 dB, 10 MHz, saida 0,5..3,7 V ----------------
Vref nref 0 PWL(0 0 3m 2.5)
Gea  0 nea nref inv 1m
Rea  nea 0 100Meg
Cea  nea 0 15.9p
Bcl  nea 0 I = 1m*(uramp(V(nea)-3.8) - uramp(0.4-V(nea)))
Beo  comp 0 V = min(max(V(nea),0.5),3.7)

* --- modulador PWM ---------------------------------------------------------
* rampa 1 -> 4 V em 19,9 us, retorno em 100 ns; saida 0..15 V para o IN
Vramp ramp 0 PULSE(1 4 0 19.9u 100n 0 20u)
Bpwm  in 0 V = 15*(0.5 + 0.5*tanh((V(comp)-V(ramp))/10m))

* --- modelos -----------------------------------------------------------------
* MOSFET de 100 V da classe do IRF540N: ~15 mohm com 15 V de gate,
* Ciss ~1,5 nF, Qg ~30 nC a 48 V.  Subcircuito (MOSFET nivel 1 + Cgs, Cgd,
* Cds e diodo de corpo explicitos) em vez de VDMOS: o VDMOS do ngspice da
* "timestep too small" de vez em quando nas bordas rapidas de gate.
.subckt NMOS100 D G S
Rg  G gi 1.5
M1  di gi S S NCH100 L=1u W=1u
Rd  D di 12m
Cgs gi S 1.4n
Cgd gi D 150p
Cds D S 300p
Dbd S D DBD100
.model NCH100 NMOS(LEVEL=1 VTO=3 KP=30 LAMBDA=0.01)
.model DBD100 D(IS=1e-12 N=1.2 RS=10m CJO=0.3n)
.ends
* diodo de bootstrap ultrarrapido.  Sem TT de proposito: a recuperacao
* reversa abrupta de um TT de dezenas de ns, a cada ciclo, derruba o passo
* de tempo do ngspice ("timestep too small") - e nao muda nada no circuito.
.model DBOOT D(IS=1n N=1.7 RS=0.1 CJO=10p)
.model SLOAD SW(Ron=1m Roff=1Meg Vt=0.5 Vh=0.1)

* gear: amortece o "ringing" numerico das comutacoes da meia-ponte
.options method=gear
* uic: parte do zero (capacitores descarregados), como uma fonte real
.tran 40n 12m 0 40n uic
.end
